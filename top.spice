* SPICE3 file created from top.ext - technology: sky130A

.lib "/opt/pdk/sky130A/libs.tech/ngspice/sky130.lib.spice" tt

.subckt top vdd vref gnd
X0 pfets_0/pfet_1/a_n60_0# net2 net6 vdd sky130_fd_pr__pfet_01v8_lvt ad=1.5 pd=10.6 as=1.5 ps=10.6 w=5 l=2
X1 vdd net2 pfets_0/pfet_1/a_n60_0# vdd sky130_fd_pr__pfet_01v8_lvt ad=12.00002 pd=84.805 as=1.50003 ps=10.605 w=5 l=2
X2 vref net2 vdd vdd sky130_fd_pr__pfet_01v8_lvt ad=3.00003 pd=21.205 as=0 ps=0 w=5 l=2
X3 vdd net2 vref vdd sky130_fd_pr__pfet_01v8_lvt ad=0 pd=0 as=0 ps=0 w=5 l=2
X4 net1 net2 vdd vdd sky130_fd_pr__pfet_01v8_lvt ad=6.00002 pd=42.405 as=0 ps=0 w=5 l=2
X5 vdd net2 net1 vdd sky130_fd_pr__pfet_01v8_lvt ad=0 pd=0 as=0 ps=0 w=5 l=2
X6 net2 net2 vdd vdd sky130_fd_pr__pfet_01v8_lvt ad=3.00003 pd=21.205 as=0 ps=0 w=5 l=2
X7 vdd net2 net2 vdd sky130_fd_pr__pfet_01v8_lvt ad=0 pd=0 as=0 ps=0 w=5 l=2
X8 net1 net2 vdd vdd sky130_fd_pr__pfet_01v8_lvt ad=0 pd=0 as=0 ps=0 w=5 l=2
X9 net2 net2 vdd vdd sky130_fd_pr__pfet_01v8_lvt ad=0 pd=0 as=0 ps=0 w=5 l=2
X10 vdd net2 net1 vdd sky130_fd_pr__pfet_01v8_lvt ad=0 pd=0 as=0 ps=0 w=5 l=2
X11 vdd net2 net2 vdd sky130_fd_pr__pfet_01v8_lvt ad=0 pd=0 as=0 ps=0 w=5 l=2
X12 vref net2 vdd vdd sky130_fd_pr__pfet_01v8_lvt ad=0 pd=0 as=0 ps=0 w=5 l=2
X13 vdd net2 vref vdd sky130_fd_pr__pfet_01v8_lvt ad=0 pd=0 as=0 ps=0 w=5 l=2
X14 net1 vdd vdd vdd sky130_fd_pr__pfet_01v8_lvt ad=0 pd=0 as=0 ps=0 w=5 l=2
X15 vdd net6 net1 vdd sky130_fd_pr__pfet_01v8_lvt ad=0 pd=0 as=0 ps=0 w=5 l=2
X16 net1 net6 vdd vdd sky130_fd_pr__pfet_01v8_lvt ad=0 pd=0 as=0 ps=0 w=5 l=2
X17 starternfet_0/a_88_252# starternfet_0/a_88_252# gnd gnd sky130_fd_pr__nfet_01v8_lvt ad=0.3 pd=2.6 as=0.3 ps=2.6 w=1 l=7
X18 net6 net6 starternfet_0/a_88_252# gnd sky130_fd_pr__nfet_01v8_lvt ad=0.3 pd=2.6 as=0.30002 ps=2.605 w=1 l=7
X19 rp1 gnd gnd gnd sky130_fd_pr__nfet_01v8_lvt ad=1.5 pd=10.6 as=1.5 ps=10.6 w=5 l=1
X20 gnd gnd gnd gnd sky130_fd_pr__nfet_01v8_lvt ad=197.72403 pd=1.12661k as=0 ps=0 w=5 l=1
X21 gnd gnd qp1 gnd sky130_fd_pr__nfet_01v8_lvt ad=0 pd=0 as=10.50002 ps=74.205 w=5 l=1
X22 gnd gnd rp1 gnd sky130_fd_pr__nfet_01v8_lvt ad=0 pd=0 as=10.50002 ps=74.205 w=5 l=1
X23 qp1 gnd gnd gnd sky130_fd_pr__nfet_01v8_lvt ad=0 pd=0 as=0 ps=0 w=5 l=1
X24 rp1 gnd gnd gnd sky130_fd_pr__nfet_01v8_lvt ad=0 pd=0 as=0 ps=0 w=5 l=1
X25 net2 net1 rp1 gnd sky130_fd_pr__nfet_01v8_lvt ad=6.00002 pd=42.405 as=0 ps=0 w=5 l=1
X26 net1 net1 qp1 gnd sky130_fd_pr__nfet_01v8_lvt ad=6.00002 pd=42.405 as=0 ps=0 w=5 l=1
X27 rp1 net1 net2 gnd sky130_fd_pr__nfet_01v8_lvt ad=0 pd=0 as=0 ps=0 w=5 l=1
X28 qp1 net1 net1 gnd sky130_fd_pr__nfet_01v8_lvt ad=0 pd=0 as=0 ps=0 w=5 l=1
X29 gnd gnd qp1 gnd sky130_fd_pr__nfet_01v8_lvt ad=0 pd=0 as=0 ps=0 w=5 l=1
X30 net1 net1 qp1 gnd sky130_fd_pr__nfet_01v8_lvt ad=0 pd=0 as=0 ps=0 w=5 l=1
X31 gnd gnd gnd gnd sky130_fd_pr__nfet_01v8_lvt ad=0 pd=0 as=0 ps=0 w=5 l=1
X32 qp1 net1 net1 gnd sky130_fd_pr__nfet_01v8_lvt ad=0 pd=0 as=0 ps=0 w=5 l=1
X33 gnd gnd rp1 gnd sky130_fd_pr__nfet_01v8_lvt ad=0 pd=0 as=0 ps=0 w=5 l=1
X34 gnd gnd gnd gnd sky130_fd_pr__nfet_01v8_lvt ad=0 pd=0 as=0 ps=0 w=5 l=1
X35 gnd gnd rp1 gnd sky130_fd_pr__nfet_01v8_lvt ad=0 pd=0 as=0 ps=0 w=5 l=1
X36 qp1 gnd gnd gnd sky130_fd_pr__nfet_01v8_lvt ad=0 pd=0 as=0 ps=0 w=5 l=1
X37 qp1 gnd gnd gnd sky130_fd_pr__nfet_01v8_lvt ad=0 pd=0 as=0 ps=0 w=5 l=1
X38 gnd gnd gnd gnd sky130_fd_pr__nfet_01v8_lvt ad=0 pd=0 as=0 ps=0 w=5 l=1
X39 net1 net1 qp1 gnd sky130_fd_pr__nfet_01v8_lvt ad=0 pd=0 as=0 ps=0 w=5 l=1
X40 qp1 net1 net1 gnd sky130_fd_pr__nfet_01v8_lvt ad=0 pd=0 as=0 ps=0 w=5 l=1
X41 net1 net1 qp1 gnd sky130_fd_pr__nfet_01v8_lvt ad=0 pd=0 as=0 ps=0 w=5 l=1
X42 qp1 net1 net1 gnd sky130_fd_pr__nfet_01v8_lvt ad=0 pd=0 as=0 ps=0 w=5 l=1
X43 gnd gnd qp1 gnd sky130_fd_pr__nfet_01v8_lvt ad=0 pd=0 as=0 ps=0 w=5 l=1
X44 rp1 gnd gnd gnd sky130_fd_pr__nfet_01v8_lvt ad=0 pd=0 as=0 ps=0 w=5 l=1
X45 net2 net1 rp1 gnd sky130_fd_pr__nfet_01v8_lvt ad=0 pd=0 as=0 ps=0 w=5 l=1
X46 rp1 net1 net2 gnd sky130_fd_pr__nfet_01v8_lvt ad=0 pd=0 as=0 ps=0 w=5 l=1
X47 net2 net1 rp1 gnd sky130_fd_pr__nfet_01v8_lvt ad=0 pd=0 as=0 ps=0 w=5 l=1
X48 rp1 net1 net2 gnd sky130_fd_pr__nfet_01v8_lvt ad=0 pd=0 as=0 ps=0 w=5 l=1
X49 net2 net1 rp1 gnd sky130_fd_pr__nfet_01v8_lvt ad=0 pd=0 as=0 ps=0 w=5 l=1
X50 rp1 net1 net2 gnd sky130_fd_pr__nfet_01v8_lvt ad=0 pd=0 as=0 ps=0 w=5 l=1
X51 resbank_0/li_1084_1992# resbank_0/li_546_0# gnd sky130_fd_pr__res_high_po_1p41 l=7.96
X52 resbank_0/li_1084_1992# resbank_0/a_1628_20# gnd sky130_fd_pr__res_high_po_1p41 l=7.96
X53 resbank_0/a_4312_1992# rp1 gnd sky130_fd_pr__res_high_po_1p41 l=7.96
X54 resbank_0/a_1628_20# resbank_0/li_2698_0# gnd sky130_fd_pr__res_high_po_1p41 l=7.96
X55 resbank_0/li_3236_1992# resbank_0/li_2698_0# gnd sky130_fd_pr__res_high_po_1p41 l=7.96
X56 resbank_0/li_3236_1992# resbank_0/li_2696_n234# gnd sky130_fd_pr__res_high_po_1p41 l=7.96
X57 resbank_0/a_4312_1992# li_1206_8736# gnd sky130_fd_pr__res_high_po_1p41 l=7.96
X58 resbank_0/li_3236_n1168# resbank_0/li_1084_n3394# gnd sky130_fd_pr__res_high_po_1p41 l=7.96
X59 resbank_0/li_4850_1992# resbank_0/li_2696_n234# gnd sky130_fd_pr__res_high_po_1p41 l=7.96
X60 resbank_0/li_4850_n1168# resbank_0/li_1084_n3394# gnd sky130_fd_pr__res_high_po_1p41 l=7.96
X61 li_1206_8736# qp2 gnd sky130_fd_pr__res_high_po_1p41 l=7.96
X62 resbank_0/li_4850_1992# resbank_0/li_5388_0# gnd sky130_fd_pr__res_high_po_1p41 l=7.96
X63 resbank_0/li_5104_2458# resbank_0/li_5388_0# gnd sky130_fd_pr__res_high_po_1p41 l=7.96
X64 resbank_0/li_4850_n1168# resbank_0/li_5670_n3160# gnd sky130_fd_pr__res_high_po_1p41 l=7.96
X65 gnd gnd gnd sky130_fd_pr__res_high_po_1p41 l=7.96
X66 gnd gnd gnd sky130_fd_pr__res_high_po_1p41 l=7.96
X67 resbank_0/li_5104_2458# resbank_0/li_5670_n3160# gnd sky130_fd_pr__res_high_po_1p41 l=7.96
X68 resbank_0/li_546_n1168# qp3 gnd sky130_fd_pr__res_high_po_1p41 l=7.96
X69 gnd gnd gnd sky130_fd_pr__res_high_po_1p41 l=7.96
X70 resbank_0/li_546_n1168# qp3 gnd sky130_fd_pr__res_high_po_1p41 l=7.96
X71 resbank_0/li_8_n702# qp3 gnd sky130_fd_pr__res_high_po_1p41 l=7.96
X72 li_1206_8736# qp2 gnd sky130_fd_pr__res_high_po_1p41 l=7.96
X73 resbank_0/li_8_n702# resbank_0/li_2698_n3160# gnd sky130_fd_pr__res_high_po_1p41 l=7.96
X74 resbank_0/li_3236_n1168# resbank_0/li_2698_n3160# gnd sky130_fd_pr__res_high_po_1p41 l=7.96
X75 gnd gnd gnd sky130_fd_pr__res_high_po_1p41 l=7.96
X76 vref resbank_0/li_546_0# gnd sky130_fd_pr__res_high_po_1p41 l=7.96
X77 gnd gnd gnd sky130_fd_pr__pnp_05v5_W3p40L3p40
X78 gnd gnd gnd sky130_fd_pr__pnp_05v5_W3p40L3p40
X79 gnd gnd gnd sky130_fd_pr__pnp_05v5_W3p40L3p40
X80 gnd gnd qp2 sky130_fd_pr__pnp_05v5_W3p40L3p40
X81 gnd gnd qp2 sky130_fd_pr__pnp_05v5_W3p40L3p40
X82 gnd gnd qp1 sky130_fd_pr__pnp_05v5_W3p40L3p40
X83 gnd gnd qp2 sky130_fd_pr__pnp_05v5_W3p40L3p40
X84 gnd gnd qp2 sky130_fd_pr__pnp_05v5_W3p40L3p40
X85 gnd gnd qp2 sky130_fd_pr__pnp_05v5_W3p40L3p40
X86 gnd gnd qp2 sky130_fd_pr__pnp_05v5_W3p40L3p40
X87 gnd gnd qp3 sky130_fd_pr__pnp_05v5_W3p40L3p40
X88 gnd gnd qp2 sky130_fd_pr__pnp_05v5_W3p40L3p40
X89 gnd gnd qp2 sky130_fd_pr__pnp_05v5_W3p40L3p40
X90 gnd gnd gnd sky130_fd_pr__pnp_05v5_W3p40L3p40
X91 gnd gnd gnd sky130_fd_pr__pnp_05v5_W3p40L3p40
X92 gnd gnd gnd sky130_fd_pr__pnp_05v5_W3p40L3p40
X93 gnd gnd gnd sky130_fd_pr__pnp_05v5_W3p40L3p40
X94 gnd gnd gnd sky130_fd_pr__pnp_05v5_W3p40L3p40
X95 gnd gnd gnd sky130_fd_pr__pnp_05v5_W3p40L3p40
X96 gnd gnd gnd sky130_fd_pr__pnp_05v5_W3p40L3p40
X97 gnd gnd gnd sky130_fd_pr__pnp_05v5_W3p40L3p40
X98 gnd gnd gnd sky130_fd_pr__pnp_05v5_W3p40L3p40
X99 gnd gnd gnd sky130_fd_pr__pnp_05v5_W3p40L3p40
X100 gnd gnd gnd sky130_fd_pr__pnp_05v5_W3p40L3p40
X101 gnd gnd gnd sky130_fd_pr__pnp_05v5_W3p40L3p40
X102 gnd gnd gnd sky130_fd_pr__pnp_05v5_W3p40L3p40
X103 gnd gnd gnd sky130_fd_pr__pnp_05v5_W3p40L3p40
X104 gnd gnd gnd sky130_fd_pr__pnp_05v5_W3p40L3p40

C0 net2 vref 2.81034f
C1 qp2 resbank_0/li_1084_n3394# 2.04113f
C2 rp1 qp2 2.39649f
C3 qp2 qp3 5.41846f
C4 net1 vref 3.79041f
C5 qp2 qp1 5.10964f
C6 vdd net2 14.30857f
C7 vdd qp1 4.14087f
C8 vdd net1 8.43256f
C9 rp1 net2 4.35008f
C10 m1_9082_n14# qp2 2.27103f
C11 net1 net2 4.587f
C12 qp3 qp1 3.85041f
C13 vdd net6 7.41009f
C14 rp1 net1 3.42395f
C15 net1 qp1 6.14596f
C16 net2 net6 4.87914f
C17 vdd vref 4.49772f
C18 m1_9082_n14# gnd 2.76945f
C19 qp2 gnd 34.7387f
C20 qp3 gnd 8.47022f
C21 li_1206_8736# gnd 3.15799f
C22 resbank_0/li_8_n702# gnd 2.28501f
C23 resbank_0/li_5104_2458# gnd 3.72084f
C24 resbank_0/li_1084_n3394# gnd 2.44028f
C25 resbank_0/a_4312_1992# gnd 4.08314f
C26 net1 gnd 14.14419f
C27 qp1 gnd 9.98387f
C28 rp1 gnd 10.23871f
C29 starternfet_0/a_88_252# gnd 2.87666f
C30 vref gnd 3.76568f
C31 net2 gnd 7.25821f
C32 vdd gnd 72.78597f
C33 net6 gnd 6.46393f

.ends top

** 1. Testbench Setup **
xtop n1 ref 0 top
Vp n1 0 dc 1.8

** 2. DC Temperature Sweep Simulation Setup **
.dc temp -40 125 1

.control
run
plot v(ref)
.endc

.end
